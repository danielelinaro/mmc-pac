module ABCDQ0(xd,xq,xa,xb,xc,omega);
output xd,xq;
input xa,xb,xc,omega;

electrical xd,xq;
electrical xa,xb,xc,omega;

parameter real GAIN = 1      alterable;
parameter real TETA_GAIN = 1 alterable;

analog begin

v(xd) <+  GAIN*(v(xa)*cos(v(omega)*$abstime*TETA_GAIN)           +
                v(xb)*cos(v(omega)*$abstime*TETA_GAIN - 2*pi/3)  +
                v(xc)*cos(v(omega)*$abstime*TETA_GAIN + 2*pi/3)) ;

v(xq) <+ -GAIN*(v(xa)*sin(v(omega)*$abstime*TETA_GAIN)           +
                v(xb)*sin(v(omega)*$abstime*TETA_GAIN - 2*pi/3)  +
                v(xc)*sin(v(omega)*$abstime*TETA_GAIN + 2*pi/3));

//v(x0) <+  GAIN*0.5*(v(xa)+v(xb)+v(xc));

end

endmodule
